* VCO + divider + VCF input attenuator (no OTA)
.param F = 220
.model opamp_buf OPAMP(aol=1e5 gbp=1e6 rin=1e12 rout=100 vsat=11)
.model SW_SCH SW (Vt=2.5 Vh=2.0 Ron=10 Roff=10Meg)
Vpos vpos 0 DC 12
Vneg vneg 0 DC -12
Vref vr 0 DC 2.5
G1 0 ramp vr 0 {F/12500}
C1 ramp 0 50n IC=0
S1 ramp 0 ramp 0 SW_SCH
A1 ramp vco vco opamp_buf
Rload vco 0 11k
;@output vco

.control
tran 20u 50m UIC
.endc
.end

* Module 3: Multi-Channel Signal Generator (VCO & LFO) - simplified sim
VDD VDD 0 DC 12

* 3 audio square channels
V1 Y1 0 PULSE(0 12 0 1u 1u 0.5m 1m)
V2 Y2 0 PULSE(0 12 0 1u 1u 0.52m 1.04m)
V3 Y3 0 PULSE(0 12 0 1u 1u 0.48m 0.96m)

* LFO
V4 Y4 0 PULSE(0 12 0 1m 1m 33m 66m)

* Summing network
Rsum1 Y1 SUM 100k
Rsum2 Y2 SUM 100k
Rsum3 Y3 SUM 100k
Rsumg SUM 0 33k

Cdec VDD 0 100n

.control
tran 10u 20m uic
wrdata /tmp/vco_lfo.cir.csv time SUM
.endc
.end
